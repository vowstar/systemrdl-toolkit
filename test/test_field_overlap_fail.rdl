// Test field overlap detection. This fixture breaks one rule only: the two
// overlaps below are the whole set of errors the elaborator must report.
// EXPECT_ELABORATION_FAILURE: Field overlap detected
addrmap test_field_overlap {
    // Field overlap within same register
    reg overlap_reg {
        regwidth = 32;

        field {
            sw = rw;
            hw = r;
            desc = "First field";
        } field1[7:0];     // bits 0-7

        field {
            sw = rw;
            hw = r;
            desc = "Overlapping field";
        } field2[3:0];     // bits 0-3, overlaps with field1

        field {
            sw = rw;
            hw = r;
            desc = "Another overlapping field";
        } field3[10:5];    // bits 5-10, overlaps with field1
    };

    overlap_reg test1 @ 0x0000;
};
