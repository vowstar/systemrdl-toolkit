// Access width wider than the register.
// EXPECT_ELABORATION_FAILURE: 10.6.1-c
//
// 10.6.1-c: "The value of the accesswidth property shall not exceed the value
// of the regwidth property." A 64-bit access to a 32-bit register would read
// beyond the register into whatever is placed after it.
addrmap test_accesswidth_gt_regwidth {

    reg too_wide_access {
        regwidth    = 32;
        accesswidth = 64;

        field {
            sw = rw;
            hw = r;
        } data[31:0];
    };

    too_wide_access reg0 @ 0x0000;
};
