// Test parameterized component functionality
addrmap test_parameterized {
    // Define parameterized register
    reg param_reg #(longint WIDTH = 32, longint RESET_VAL = 0) {
        field {
            sw = rw;
            hw = r;
            reset = RESET_VAL;
            desc = "Parameterized data field";
        } data[WIDTH-1:0];
    };

    // Define parameterized register file
    regfile param_regfile #(longint NUM_REGS = 4, longint BASE_ADDR = 0) {
        param_reg #(.WIDTH(16), .RESET_VAL(0xABCD)) regs[NUM_REGS] @ BASE_ADDR += 0x4;
    };

    // Instantiate registers with different configurations
    param_reg #(.WIDTH(8), .RESET_VAL(0x55)) reg8 @ 0x0000;
    param_reg #(.WIDTH(16), .RESET_VAL(0x1234)) reg16 @ 0x0004;
    param_reg #(.WIDTH(32), .RESET_VAL(0xDEADBEEF)) reg32 @ 0x0008;

    // Use default parameter values
    param_reg reg_default @ 0x0010;

    // Instantiate parameterized register files
    param_regfile #(.NUM_REGS(8), .BASE_ADDR(0x1000)) regfile1;
    param_regfile #(.NUM_REGS(2), .BASE_ADDR(0x2000)) regfile2;

    // Define parameterized memory
    mem param_mem #(longint SIZE = 1024, string TYPE = "ram") {
        memwidth = 32;  // 32-bit memory width
        // Memory attributes can be set based on parameters
    };

    // Instantiate memories of different sizes
    external param_mem #(.SIZE(2048), .TYPE("cache")) cache_mem @ 0x10000000;
    external param_mem #(.SIZE(4096), .TYPE("buffer")) buffer_mem @ 0x20000000;

    // Use memory with default parameters
    external param_mem default_mem @ 0x30000000;
};