// Test Memory component functionality
addrmap memory_system {
    // Define basic memory types
    mem ram_mem {
        // Memory typically has no internal structure, but can have attributes
    };

    mem rom_mem {
        // ROM memory
    };

    // Instantiate different types of memory
    ram_mem main_ram @ 0x10000000;
    rom_mem boot_rom @ 0x00000000;

    // Memory array
    ram_mem buffer_array[8] @ 0x20000000 += 0x1000;

    // Mixed system: registers + memory
    reg control_reg {
        field {
            sw = rw;
            hw = r;
            desc = "Memory controller enable";
        } enable[0:0];

        field {
            sw = rw;
            hw = r;
            desc = "Memory size configuration";
        } size_config[15:8];

        field {
            sw = r;
            hw = w;
            desc = "Memory status";
        } status[31:16];
    };

    control_reg mem_ctrl @ 0x40000000;

    // Anonymous memory definition and instantiation
    mem {
        // Large capacity memory
    } large_memory @ 0x80000000;

    // Small cache memory array
    mem {
        // Cache memory
    } cache_mem[4] @ 0x50000000 += 0x10000;
};