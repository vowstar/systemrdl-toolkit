// Test field overlap detection
// EXPECT_ELABORATION_FAILURE: This test is designed to fail during elaboration to validate field overlap detection
addrmap test_field_overlap {
    // Test 1: Field overlap within same register
    reg overlap_reg {
        regwidth = 32;

        field {
            sw = rw;
            hw = r;
            desc = "First field";
        } field1[7:0];     // bits 0-7

        field {
            sw = rw;
            hw = r;
            desc = "Overlapping field";
        } field2[3:0];     // bits 0-3, overlaps with field1

        field {
            sw = rw;
            hw = r;
            desc = "Another overlapping field";
        } field3[10:5];    // bits 5-10, overlaps with field1
    };

    // Test 2: Field exceeding register width
    reg boundary_reg {
        regwidth = 16;

        field {
            sw = rw;
            hw = r;
            desc = "Field exceeding boundary";
        } big_field[31:0]; // 32 bits, but register is only 16 bits
    };

    // Test 3: Field with invalid bit range (MSB < LSB)
    reg invalid_range_reg {
        regwidth = 32;

        field {
            sw = rw;
            hw = r;
            desc = "Invalid bit range";
        } invalid_field[5:10]; // MSB(5) < LSB(10), invalid
    };

    overlap_reg test1 @ 0x0000;
    boundary_reg test2 @ 0x0004;
    invalid_range_reg test3 @ 0x0008;
};