// Simple SystemRDL example for testing the library

addrmap example_chip {
    name = "Example Chip";
    desc = "A simple example chip for demonstrating SystemRDL library usage";

    reg {
        name = "Control Register";
        desc = "Main control register";
        regwidth = 32;

        field {
            name = "ENABLE";
            desc = "Enable control bit";
            sw = rw;
            hw = r;
        } enable[0:0] = 0;

        field {
            name = "MODE";
            desc = "Operation mode selection";
            sw = rw;
            hw = r;
        } mode[2:1] = 0;

        field {
            name = "RESERVED";
            desc = "Reserved bits";
            sw = r;
            hw = na;
        } reserved[31:3] = 0;

    } control_reg @ 0x0000;

    reg {
        name = "Status Register";
        desc = "Status and error reporting";
        regwidth = 32;

        field {
            name = "READY";
            desc = "System ready status";
            sw = r;
            hw = w;
        } ready[0:0] = 0;

        field {
            name = "ERROR";
            desc = "Error flag";
            sw = r;
            hw = w;
        } error[1:1] = 0;

        field {
            name = "COUNT";
            desc = "Status counter";
            sw = r;
            hw = w;
        } count[15:8] = 0;

    } status_reg @ 0x0004;

    reg {
            name = "Data Register";
        desc = "Data input/output register";
        regwidth = 32;

        field {
            name = "DATA";
            desc = "32-bit data field";
                sw = rw;
                hw = rw;
        } data[31:0] = 0x12345678;

    } data_reg @ 0x0008;
        };